First-order RC low-pass, fc = 1.59 kHz
V1 in 0 DC 5 AC 1
R1 in out 1k
C1 out 0 100n
.end
